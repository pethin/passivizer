* Passivizer Netlist 15: Passive Character (Dynamic Metallurgy / No EQ)
* Target: Pure Passive Magnetic Character & Dynamic Feel for Active Basses (Flat 0 dB Linear Transfer)
* Mode: no_eq
.options plotwinsize=0 numdgt=7

* 1. Audio Source (NAM Training Track)
V_in in 0 wavefile="T3K-sweep-v3.wav"

* 2. Dynamic Magnetic Core & String Excursion Saturation (Alnico V Soft-Knee)
B_comp in_dyn 0 V=0.50 * tanh(V(in) / 0.50)

* 3. Reference Passive Pickup Coils (Alnico V High-Z Twin)
L_coil in_dyn node1 3.60
R_dc node1 node2 8.20k
R_eddy in_dyn node2 120k
C_coil node2 0 80p

* 4. 250k Volume Pot (Volume @ 100%)
R_pot_top node2 node3 10
R_pot_bot node3 0 250k

* 5. Instrument Cable Load (~750pF)
C_cable node3 0 750p

* 6. Darkglass Anagram Input Stage (1 M-Ohm || 30pF)
R_anagram node3 0 1Meg
C_anagram node3 0 30p

* 7. Output Audio Export for NAM Training
.wave "out_15_passive_character.wav" 24 48000 V(node3)
.end
