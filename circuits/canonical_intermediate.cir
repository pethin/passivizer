* Allomorph Canonical Intermediate Netlist
* Universal Architecture C Reference Baseline
* Pure Linear Unity Active Studio Buffer (Gain = 1.00, flat 0.00 dB)
* mode: no_eq
.options plotwinsize=0 numdgt=7

* 1. Audio Source (NAM Training Track)
V_in in 0 wavefile="T3K-sweep-v3.wav"

* 2. Pure Linear Active Buffer (Gain = 1.00, flat 0.00 dB, R_in = 10Meg)
R_in in 0 10Meg
E_buf out 0 in 0 1.0

* 3. Low-Z Output Stage Load
R_out out 0 50

* 4. Output Audio Export
.wave "canonical_sweep.wav" 24 48000 V(out)
.end
