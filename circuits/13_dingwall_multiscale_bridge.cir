* Allomorph Netlist 13: Dingwall Fanned-Fret Bridge (Multi-Scale)
* Target: Multi-Scale Angled Dual-Coil Bridge Sweet Spot with Active Buffer
.options plotwinsize=0 numdgt=7

* 1. Audio Source (Pre-filtered NAM Training Track)
V_in in 0 wavefile="T3K-sweep-v3.wav"

* 2. Dynamic Magnetic Core & String Excursion Saturation (Soft-Knee Compliance)
B_comp in_dyn 0 V=0.90 * tanh(V(in) / 0.90)

* 3. Pickup Coils (Dingwall FD3 Dual Coils in Parallel)
L_coil in_dyn node1 2.3
R_dc node1 node2 4.4k
R_eddy in_dyn node2 150k
C_coil node2 0 120p

* 4. Active Buffer Input Stage (High-Z Input Buffer, Zero Cable Drag on Coils)
R_preamp_in node2 0 1Meg
C_preamp_in node2 0 25p

* 5. Active Buffer Output Stage (Flat Active Buffer)
* Direct low-Z op-amp output buffer isolating coils from cable capacitance
E_preamp node_buf 0 node2 0 1.0
R_out node_buf node3 100
* Preamp voicing: none (flat buffer)

* 6. Instrument Cable Load (15-ft cable ~750pF driven by low-Z buffer)
C_cable node3 0 750p

* 7. Darkglass Anagram Input Stage (1 M-Ohm || 30pF)
R_anagram node3 0 1Meg
C_anagram node3 0 30p

* 8. Output Audio Export for NAM Training
.wave "out_13_dingwall_multiscale_bridge.wav" 24 48000 V(node3)
.end
