* Passivizer Netlist 13: Dingwall Fanned-Fret Bridge (Multi-Scale)
* Target: Multi-Scale Angled Dual-Coil Bridge Sweet Spot with Dingwall Factory 500k V/T Harness
.options plotwinsize=0 numdgt=7

* 1. Audio Source (Pre-filtered NAM Training Track)
V_in in 0 wavefile="v1_1_1_aperture.wav"

* 2. Dynamic Magnetic Core & String Excursion Saturation (Soft-Knee Compliance)
B_comp in_dyn 0 V=0.55 * tanh(V(in) / 0.55)

* 3. Pickup Coils (Dingwall FD3 Dual Coils in Parallel)
L_coil in_dyn node1 2.3
R_dc node1 node2 4.4k
R_eddy in_dyn node2 150k
C_coil node2 0 120p

* 4. Dingwall Factory Passive Tone Pot (500k Audio with 47nF Capacitor)
R_tone node2 tone_mid 500k
C_tone tone_mid 0 47n

* 5. Dingwall Factory 500k Volume Pot (Volume @ 100%)
R_pot_top node2 node3 10
R_pot_bot node3 0 500k

* 6. Instrument Cable Load (15-ft cable ~750pF)
C_cable node3 0 750p

* 7. Darkglass Anagram Input Stage (1 M-Ohm || 30pF)
R_anagram node3 0 1Meg
C_anagram node3 0 30p

* 8. Output Audio Export for NAM Training
.wave "out_13_dingwall_multiscale_bridge.wav" 24 48000 V(node3)
.end
