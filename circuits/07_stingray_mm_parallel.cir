* Passivizer Netlist 07: Music Man MM (Parallel Humbucker)
* Target: Dual-Coil Parallel Humbucker (0.75" Spacing Comb + 3.5 kHz Peak)
.options plotwinsize=0 numdgt=7

* 1. Audio Source (Pre-filtered NAM Training Track)
V_in in 0 wavefile="v1_1_1_aperture.wav"

* 2. Pickup Coils (Bartolini MM4CBC Dual Coils in Parallel)
L_coil in node1 2.4
R_dc node1 node2 4.6k
R_eddy in node2 140k
C_coil node2 0 130p

* 3. Dunlop 500k Super Pot (Volume @ 100%)
R_pot_top node2 node3 10
R_pot_bot node3 0 500k

* 4. Dunlop Hybrid Treble Bleed (Lug 3 to Lug 2)
C_tb node2 tb_mid 1.0n
R_tb_par node2 tb_mid 150k
R_tb_ser tb_mid node3 20k

* 5. Instrument Cable Load (15-ft cable ~750pF)
C_cable node3 0 750p

* 6. Darkglass Anagram Input Stage (1 M-Ohm || 30pF)
R_anagram node3 0 1Meg
C_anagram node3 0 30p

* 7. Transient Execution (48 kHz sample interval)
.tran 0 180 0 20.8333u

* 8. Output Audio Export for NAM Training
.wave "out_07_stingray_mm_parallel.wav" 24 48000 V(node3)
.end
