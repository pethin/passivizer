* Passivizer Netlist 09: P/MM Hybrid (Series Sum)
* Target: Split-P + MM Dual-Coil in Series (7.2H Inductive Sum, 2.0 kHz Peak)
.options plotwinsize=0 numdgt=7

* 1. Audio Sources: Independent String Motion per Pickup (Channel 0 = P-Neck, Channel 1 = MM-Bridge)
V_neck in_neck 0 wavefile="v1_1_1_aperture.wav" chan=0
V_bridge in_bridge node_mid wavefile="v1_1_1_aperture.wav" chan=1

* 2. Dynamic Magnetic Core & String Excursion Saturation (Soft-Knee Compliance)
B_comp_n in_dyn_n 0 V=0.40 * tanh(V(in_neck) / 0.40)
B_comp_b in_dyn_b node_mid V=0.40 * tanh(V(in_bridge, node_mid) / 0.40)

* 3. Pickup Coils: P/MM in Series Sum (Precision Neck + Music Man Bridge)
* --- Stage 1: Bartolini 8CBP Precision Neck (4.8H, 9.5k, 80pF, 110k eddy) ---
L_neck in_dyn_n node1_n 4.80
R_dc_n node1_n node_mid 9.50k
R_eddy_n in_dyn_n node_mid 110k
C_coil_n node_mid 0 80p

* --- Stage 2: Bartolini MM4CBC Music Man Bridge (2.4H, 4.6k, 90pF, 85k eddy) ---
L_bridge in_dyn_b node1_b 2.40
R_dc_b node1_b node2 4.60k
R_eddy_b in_dyn_b node2 85k
C_coil_b node2 node_mid 90p

* 3. 500k Volume Pot (Volume @ 100%)
R_pot_top node2 node3 10
R_pot_bot node3 0 500k

* 4. Hybrid Treble Bleed (Lug 3 to Lug 2)
C_tb node2 tb_mid 1.0n
R_tb_par node2 tb_mid 150k
R_tb_ser tb_mid node3 20k

* 5. Instrument Cable Load (15-ft cable ~750pF)
C_cable node3 0 750p

* 6. Darkglass Anagram Input Stage (1 M-Ohm || 30pF)
R_anagram node3 0 1Meg
C_anagram node3 0 30p

* 7. Transient Execution (48 kHz sample interval)
.tran 0 190 0 20.833333333333333u

* 8. Output Audio Export for NAM Training
.wave "out_09_pmm_hybrid_series.wav" 24 48000 V(node3)
.end
