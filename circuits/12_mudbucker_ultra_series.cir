* Passivizer Netlist 12: Mudbucker Ultra Series
* Target: Ultra-High Inductance Overwound Dual-Coil Series with Authentic Gibson 500k V/T (22nF Cap)
.options plotwinsize=0 numdgt=7

* 1. Audio Source (Pre-filtered NAM Training Track)
V_in in 0 wavefile="v1_1_1_aperture.wav"

* 2. Dynamic Magnetic Core & String Excursion Saturation (Soft-Knee Compliance)
B_comp in_dyn 0 V=0.35 * tanh(V(in) / 0.35)

* 3. Pickup Coils (Ultra-High Inductance Dark Series Coils)
L_coil in_dyn node1 14.4
R_dc node1 node2 27.9k
R_eddy in_dyn node2 80k
C_coil node2 0 80p

* 4. Historic Gibson Tone Pot (500k Audio with 22nF Capacitor)
R_tone node2 tone_mid 500k
C_tone tone_mid 0 22n

* 5. Historic Gibson 500k Volume Pot (Volume @ 100%)
R_pot_top node2 node3 10
R_pot_bot node3 0 500k

* 6. Instrument Cable Load (15-ft cable ~750pF)
C_cable node3 0 750p

* 7. Darkglass Anagram Input Stage (1 M-Ohm || 30pF)
R_anagram node3 0 1Meg
C_anagram node3 0 30p

* 8. Output Audio Export for NAM Training
.wave "out_12_mudbucker_ultra_series.wav" 24 48000 V(node3)
.end
