* Passivizer Source Netlist: Standard 34" Fender Jazz Bass (Solo Bridge)
* Physical Spec: Vintage Alnico V Bridge Single-Coil (7.8k Rdc, 3.6H L, 125k Reddy, 70pF Ccoil)
* Electronics: Stock 250k Audio Volume Pot, 250k Tone Pot (100% Wide Open, 47nF Cap), 750pF Cable
.options plotwinsize=0 numdgt=7

* 1. Audio Source (Pre-filtered NAM Calibration Track)
V_in in 0 wavefile="v1_1_1.wav"

* 2. Pickup Coils (Standard Fender Jazz Bridge Single-Coil)
L_coil in node1 3.60
R_dc node1 node2 7.80k
R_eddy in node2 125k
C_coil node2 0 70p

* 3. Tone Pot (100% Wide Open: 250k series resistance with 47nF capacitor)
R_tone node2 tone_mid 250k
C_tone tone_mid 0 47n

* 4. 250k Volume Pot (Volume @ 100%)
R_pot_top node2 node3 10
R_pot_bot node3 0 250k

* 5. Instrument Cable Load (15-ft cable ~750pF)
C_cable node3 0 750p

* 6. Darkglass Anagram Input Stage (1 M-Ohm || 30pF)
R_anagram node3 0 1Meg
C_anagram node3 0 30p

.end
