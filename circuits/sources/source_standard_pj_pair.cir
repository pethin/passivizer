* Passivizer Source Netlist: Standard 34" P/J Bass (Both Pickups in Parallel)
* Physical Spec: Vintage Alnico V Split-P Neck || Vintage Alnico V Jazz Bridge in Parallel
* Electronics: Dual 250k Audio Volume Pots (125k net load), 250k Tone Pot (100% Wide Open, 47nF Cap), 750pF Cable
.options plotwinsize=0 numdgt=7

* 1. Audio Sources: Independent String Motion per Pickup (Channel 0 = P-Neck, Channel 1 = J-Bridge)
V_neck in_neck 0 wavefile="T3K-sweep-v3.wav" chan=0
V_bridge in_bridge 0 wavefile="T3K-sweep-v3.wav" chan=1

* 2. Pickup Coils: Dual Parallel Pickup Branches (Vintage Split-P || 60s Jazz Bridge)
* --- Branch 1: Vintage '62 Split-P Alnico V (3.8H, 10.5k, 60pF, 180k eddy) ---
L_neck in_neck node1_n 3.80
R_dc_n node1_n node2 10.50k
R_eddy_n in_neck node2 180k
C_coil_n node2 0 60p

* --- Branch 2: Vintage 60s Jazz Bridge Alnico V (3.6H, 7.8k, 70pF, 125k eddy) ---
L_bridge in_bridge node1_b 3.60
R_dc_b node1_b node2 7.80k
R_eddy_b in_bridge node2 125k
C_coil_b node2 0 70p

* 3. Tone Pot (100% Wide Open: 250k series resistance with 47nF capacitor)
R_tone node2 tone_mid 250k
C_tone tone_mid 0 47n

* 4. Dual 250k Volume Pots in Parallel (Volume @ 100%: 250k || 250k = 125k)
R_pot_top node2 node3 10
R_pot_bot node3 0 125k

* 5. Instrument Cable Load (15-ft cable ~750pF)
C_cable node3 0 750p

* 6. Darkglass Anagram Input Stage (1 M-Ohm || 30pF)
R_anagram node3 0 1Meg
C_anagram node3 0 30p

.end
