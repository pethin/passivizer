* Allomorph Netlist 16: Active Character (Modern Active Buffer)
* Target: Studio High-Impedance Active Buffer Twin (Cable Isolation & Wideband Sparkle)
.options plotwinsize=0 numdgt=7

* 1. Audio Source (NAM Training Track)
V_in in 0 wavefile="T3K-sweep-v3.wav"

* 2. Dynamic Compliance Stage (High Active Headroom, Vsat = 1.20)
B_comp in_dyn 0 V=1.20 * tanh(V(in) / 1.20)

* 3. Pickup Coils (Buffered Wideband Coils)
L_coil in_dyn node1 3.20
R_dc node1 node2 7.20k
R_eddy in_dyn node2 135k
C_coil node2 0 70p

* 4. Active Buffer Input Stage (High-Z Input Buffer, Zero Cable Drag on Coils)
R_preamp_in node2 0 1Meg
C_preamp_in node2 0 25p

* 5. Active Buffer Output Stage (Flat Studio Buffer, Zero Active EQ)
* Direct low-Z op-amp output buffer isolating coils from cable capacitance
E_preamp node_buf 0 node2 0 1.0
R_out node_buf node3 100
* Preamp voicing: none (flat buffer)

* 6. Instrument Cable Load (15-ft cable ~750pF driven by low-Z buffer)
C_cable node3 0 750p

* 7. Darkglass Anagram Input Stage (1 M-Ohm || 30pF)
R_anagram node3 0 1Meg
C_anagram node3 0 30p

* 8. Output Audio Export for NAM Training
.wave "out_16_active_character.wav" 24 48000 V(node3)
.end
