* Passivizer Netlist 01: Modern Active Jazz Bass Pair
* Target: Dual Single-Coil Pair in 60s Spacing with Active 2-Band Preamp Buffer (Sadowsky Style)
.options plotwinsize=0 numdgt=7

* 1. Audio Sources: Independent String Motion per Pickup (Channel 0 = Neck, Channel 1 = Bridge)
V_neck in_neck 0 wavefile="T3K-sweep-v3.wav" chan=0
V_bridge in_bridge 0 wavefile="T3K-sweep-v3.wav" chan=1

* 2. Dynamic Magnetic Core & String Excursion Saturation (Soft-Knee Compliance)
B_comp_n in_dyn_n 0 V=0.40 * tanh(V(in_neck) / 0.40)
B_comp_b in_dyn_b 0 V=0.60 * tanh(V(in_bridge) / 0.60)

* 3. Pickup Coils: Dual Parallel Pickup Branches in 60s Spacing
* --- Branch 1: Bartolini 9CBJS1 Neck Single-Coil (3.2H, 7.2k, 70pF, 135k eddy) ---
L_neck in_dyn_n node1_n 3.20
R_dc_n node1_n node2 7.20k
R_eddy_n in_dyn_n node2 135k
C_coil_n node2 0 70p

* --- Branch 2: Bartolini 9CBJS1 Bridge Single-Coil (3.6H, 7.8k, 70pF, 125k eddy) ---
L_bridge in_dyn_b node1_b 3.60
R_dc_b node1_b node2 7.80k
R_eddy_b in_dyn_b node2 125k
C_coil_b node2 0 70p

* 4. Active Preamp Input Stage (High-Z Input Buffer, Zero Cable Drag on Coils)
R_preamp_in node2 0 1Meg
C_preamp_in node2 0 25p

* 5. Active Preamp Buffer Stage (Sadowsky 2-Band Active Contour)
* Direct low-Z op-amp output buffer isolating coils from cable capacitance
E_preamp node_buf 0 node2 0 1.0
R_out node_buf node3 100
* Preamp voicing: sadowsky_2band (+3.5 dB @ 40 Hz, +3.5 dB @ 4 kHz)

* 6. Instrument Cable Load (15-ft cable ~750pF)
C_cable node3 0 750p

* 7. Darkglass Anagram Input Stage (1 M-Ohm || 30pF)
R_anagram node3 0 1Meg
C_anagram node3 0 30p

* 8. Output Audio Export for NAM Training
.wave "out_01_modern_jazz_active.wav" 24 48000 V(node3)
.end
