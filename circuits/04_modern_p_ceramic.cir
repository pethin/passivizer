* Allomorph Netlist 04: Modern Split-Coil P (Ceramic)
* Target: Modern High-Inductance Ceramic Split-P with Boutique 500k V/T Harness
.options plotwinsize=0 numdgt=7

* 1. Audio Source (Pre-filtered NAM Training Track)
V_in in 0 wavefile="T3K-sweep-v3.wav"

* 2. Dynamic Magnetic Core & String Excursion Saturation (Soft-Knee Compliance)
B_comp in_dyn 0 V=0.45 * tanh(V(in) / 0.45)

* 3. Pickup Coils (Bartolini 8CBP Ceramic Split-P)
L_coil in_dyn node1 4.8
R_dc node1 node2 9.5k
R_eddy in_dyn node2 110k
C_coil node2 0 80p

* 4. Modern Tone Pot (500k Audio with 22nF Capacitor)
R_tone node2 tone_mid 500k
C_tone tone_mid 0 22n

* 5. 500k Volume Pot (Volume @ 100%)
R_pot_top node2 node3 10
R_pot_bot node3 0 500k

* 6. Hybrid Treble Bleed (Lug 3 to Lug 2)
C_tb node2 tb_mid 1.0n
R_tb_par node2 tb_mid 150k
R_tb_ser tb_mid node3 20k

* 7. Instrument Cable Load (15-ft cable ~750pF)
C_cable node3 0 750p

* 8. Darkglass Anagram Input Stage (1 M-Ohm || 30pF)
R_anagram node3 0 1Meg
C_anagram node3 0 30p

* 9. Output Audio Export for NAM Training
.wave "out_04_modern_p_ceramic.wav" 24 48000 V(node3)
.end
