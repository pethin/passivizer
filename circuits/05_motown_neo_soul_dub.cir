* Passivizer Netlist 05: Motown / Neo-Soul / Dub P-Bass (Tone Rolled Off to 0)
* Target: Bartolini 8CBP with 47nF Tone Capacitor engaged (Pillowy sub-thump)
.options plotwinsize=0 numdgt=7

* 1. Audio Source (Pre-filtered NAM Training Track)
V_in in 0 wavefile="v1_1_1_aperture.wav"

* 2. Pickup Coils (Bartolini 8CBP Ceramic Split-P)
L_coil in node1 4.8
R_dc node1 node2 9.5k
R_eddy in node2 110k
C_coil node2 0 80p

* 3. Tone Pot Rolled Off (0 Ohm resistance, direct 47nF shunted to ground)
C_tone node2 0 47n

* 4. Dunlop 500k Super Pot (Volume @ 100%)
R_pot_top node2 node3 10
R_pot_bot node3 0 500k

* 5. Dunlop Hybrid Treble Bleed (Lug 3 to Lug 2)
C_tb node2 tb_mid 1.0n
R_tb_par node2 tb_mid 150k
R_tb_ser tb_mid node3 20k

* 6. Instrument Cable Load (15-ft cable ~750pF)
C_cable node3 0 750p

* 7. Darkglass Anagram Input Stage (1 M-Ohm || 30pF)
R_anagram node3 0 1Meg
C_anagram node3 0 30p

* 8. Transient Execution (48 kHz sample interval)
.tran 0 180 0 20.8333u

* 9. Output Audio Export for NAM Training
.wave "out_05_motown_neo_soul_dub.wav" 24 48000 V(node3)
.end
