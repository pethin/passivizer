* Allomorph Netlist 05c: Vintage '62 Split-Coil P (47nF ToneStyler)
* Target: 1962 Vintage Alnico V Split-Coil with 47nF ToneStyler pure capacitive shunt (193 Hz Peak)
.options plotwinsize=0 numdgt=7

* 1. Audio Source (Pre-filtered NAM Training Track)
V_in in 0 wavefile="T3K-sweep-v3.wav"

* 2. Dynamic Magnetic Core & String Excursion Saturation (Soft-Knee Compliance)
B_comp in_dyn 0 V=0.45 * tanh(V(in) / 0.45)

* 3. Pickup Coils (Vintage Alnico V Split-P)
L_coil in_dyn node1 3.8
R_dc node1 node2 10.5k
R_eddy in_dyn node2 180k
C_coil node2 0 60p

* 4. Tone Control (ToneStyler 47nF Position: pure capacitive shunt, 3.3 Ohm contact ESR)
R_tone node2 node2_c 3.3
C_tone node2_c 0 47n

* 5. 250k Volume Pot (Volume @ 100%)
R_pot_top node2 node3 10
R_pot_bot node3 0 250k

* 6. Instrument Cable Load (15-ft cable ~750pF)
C_cable node3 0 750p

* 7. Darkglass Anagram Input Stage (1 M-Ohm || 30pF)
R_anagram node3 0 1Meg
C_anagram node3 0 30p

* 8. Output Audio Export for NAM Training
.wave "out_05c_vintage_62_p_47nf.wav" 24 48000 V(node3)
.end
