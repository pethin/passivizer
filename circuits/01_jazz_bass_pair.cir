* Passivizer Netlist 01: Jazz Bass Pair in Parallel
* Target: Dual Single-Coil Pair in Parallel (Aperture Sinc Scoop + 3.9 kHz Peak)
.options plotwinsize=0 numdgt=7

* 1. Audio Source (Pre-filtered NAM Training Track)
V_in in 0 wavefile="v1_1_1_aperture.wav"

* 2. Dynamic Magnetic Core & String Excursion Saturation (Soft-Knee Compliance)
B_comp in_dyn 0 V=0.55 * tanh(V(in) / 0.55)

* 3. Pickup Coils: Dual Parallel Pickup Branches (J-Neck || J-Bridge)
* --- Branch 1: Bartolini 9CBJS1 Neck Single-Coil (3.2H, 7.2k, 70pF, 135k eddy) ---
L_neck in_dyn node1_n 3.20
R_dc_n node1_n node2 7.20k
R_eddy_n in_dyn node2 135k
C_coil_n node2 0 70p

* --- Branch 2: Bartolini 9CBJS1 Bridge Single-Coil (3.6H, 7.8k, 70pF, 125k eddy) ---
L_bridge in_dyn node1_b 3.60
R_dc_b node1_b node2 7.80k
R_eddy_b in_dyn node2 125k
C_coil_b node2 0 70p

* 3. Dunlop 500k Super Pot (Volume @ 100%)
R_pot_top node2 node3 10
R_pot_bot node3 0 500k

* 4. Dunlop Hybrid Treble Bleed (Lug 3 to Lug 2)
C_tb node2 tb_mid 1.0n
R_tb_par node2 tb_mid 150k
R_tb_ser tb_mid node3 20k

* 5. Instrument Cable Load (15-ft cable ~750pF)
C_cable node3 0 750p

* 6. Darkglass Anagram Input Stage (1 M-Ohm || 30pF)
R_anagram node3 0 1Meg
C_anagram node3 0 30p

* 7. Transient Execution (48 kHz sample interval)
.tran 0 190 0 20.833333333333333u

* 8. Output Audio Export for NAM Training
.wave "out_01_jazz_bass_pair.wav" 24 48000 V(node3)
.end
