* Allomorph Netlist 02c: 60s Jazz Bass Bridge Growl (Jaco Bias)
* Target: Vintage 60s Dual Single-Coil with Bridge @ 100%, Neck @ 75% (Signature Vocal Mid-Growl)
.options plotwinsize=0 numdgt=7

* 1. Audio Sources: Independent String Motion per Pickup (Channel 0 = Neck, Channel 1 = Bridge)
V_neck in_neck 0 wavefile="T3K-sweep-v3.wav" chan=0
V_bridge in_bridge 0 wavefile="T3K-sweep-v3.wav" chan=1

* 2. Dynamic Magnetic Core & String Excursion Saturation (Soft-Knee Compliance)
B_comp_n in_dyn_n 0 V=0.40 * tanh(V(in_neck) / 0.40)
B_comp_b in_dyn_b 0 V=0.60 * tanh(V(in_bridge) / 0.60)

* 3. Pickup Coils: Dual Parallel Pickup Branches in 60s Spacing (155.6mm Neck, 63.5mm Bridge)
* --- Branch 1: Vintage Neck Single-Coil decoupled by 75% Volume Pot (55k series wiper resistance) ---
L_neck in_dyn_n node1_n 3.20
R_dc_n node1_n node2_n 7.20k
R_eddy_n in_dyn_n node2_n 135k
C_coil_n node2_n 0 70p
R_pot_n node2_n node2 55k

* --- Branch 2: Vintage Bridge Single-Coil @ 100% Volume (Direct connection to output bus) ---
L_bridge in_dyn_b node1_b 3.60
R_dc_b node1_b node2 7.80k
R_eddy_b in_dyn_b node2 125k
C_coil_b node2 0 70p

* 4. Tone Pot (100% Wide Open: 250k series resistance with 47nF capacitor)
R_tone node2 tone_mid 250k
C_tone tone_mid 0 47n

* 5. Dual Volume Pot Load (Bridge 250k || Neck ground track ~195k = 109k net pot load)
R_pot_top node2 node3 10
R_pot_bot node3 0 109k

* 6. Instrument Cable Load (15-ft cable ~750pF)
C_cable node3 0 750p

* 7. Darkglass Anagram Input Stage (1 M-Ohm || 30pF)
R_anagram node3 0 1Meg
C_anagram node3 0 30p

* 8. Output Audio Export for NAM Training
.wave "out_02c_jazz_bridge_growl_bias.wav" 24 48000 V(node3)
.end
