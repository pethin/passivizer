* Passivizer Netlist 03: 60s Jazz Bass Bridge Single-Coil
* Target: 60s Bridge Single-Coil (63.5mm from Bridge, Focused 1.2 kHz Midrange Bark)
.options plotwinsize=0 numdgt=7

* 1. Audio Source (Pre-filtered NAM Training Track)
V_in in 0 wavefile="v1_1_1_aperture.wav"

* 2. Dynamic Magnetic Core & String Excursion Saturation (Soft-Knee Compliance)
B_comp in_dyn 0 V=0.55 * tanh(V(in) / 0.55)

* 3. Pickup Coils (Standard Fender Jazz Bridge Single-Coil in 60s Position)
L_coil in_dyn node1 3.60
R_dc node1 node2 7.80k
R_eddy in_dyn node2 125k
C_coil node2 0 70p

* 4. Tone Pot (100% Wide Open: 250k series resistance with 47nF capacitor)
R_tone node2 tone_mid 250k
C_tone tone_mid 0 47n

* 5. 250k Volume Pot (Volume @ 100%)
R_pot_top node2 node3 10
R_pot_bot node3 0 250k

* 6. Instrument Cable Load (15-ft cable ~750pF)
C_cable node3 0 750p

* 7. Darkglass Anagram Input Stage (1 M-Ohm || 30pF)
R_anagram node3 0 1Meg
C_anagram node3 0 30p

* 8. Output Audio Export for NAM Training
.wave "out_03_jazz_bridge_60s.wav" 24 48000 V(node3)
.end
